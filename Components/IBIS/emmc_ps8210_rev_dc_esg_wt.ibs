| emmc_ps8210_rev_dc_esg_wt.ibs * IBIS 4.2 Model
| eMMC Memory 4.51 compliant
| This Model is valid for Temperature Range -25C<=Ta<=85C
|Valid Part Numbers
|DID   Part Number   Type   Package   IBIS COMPONENT
|J54A  MTFC4GACAAAM-1M WT   4GB 4.51   153b 11.5x13x1.0  J54A_153b_11p5x13
|J54K  MTFC4GMCDM-1M WT   4GB 4.51   153b 11.5x13x1.2  MTFCxGxCDM-1M
|J54K  MTFC4GMCAM-1M WT   4GB 4.51   153b 11.5x13x1.0  MTFCxGxCDM-1M
|J55A  MTFC8GACAAAM-1M WT   8GB 4.51   153b 11.5x13x1.0  J54A_153b_11p5x13
|J55U  MTFC8GLCDM-1M WT   8GB 4.51   153b 11.5x13x1.2  MTFCxGxCDM-1M
|J56W  MTFC16GAAAADV-2M WT  16GB 4.51   169b 12.0x16x1.0  J56W_169b
[IBIS ver]   5.0
[File name]  emmc_ps8210_rev_dc_esg_wt.ibs
[File Rev]   1.5
[Date]   November 17, 2014
[Source]   From silicon level SPICE model at Micron Technology, Inc.
   For support send e-mail to modelsupport@micron.com
[Notes]   Revision History:
   1.0: March 21, 2013
   - Pre-silicon model from parasitic extracted netlist
   1.1: May 28, 2013
   - Added _wt suffix to the filename.
   1.2: September 12, 2013
   - Renamed drive strenths configurations
   (using impedance @VDDQ/2 resulting form DC curves).
   - Added new PNs: MTFC4GACAAAM-1M WT, MTFC8GACAAAM-1M WT
   1.3: October 7, 2013
   - Added new PNs: MTFC4GMCAM-1M WT
   1.4: November 20, 2013
   - Added new PNs: MTFC16GAAAADV-WT, MTFC16GAAAADV-2M WT
   1.5: November 17, 2014
   J54K_155U_153b_RLC_matrix package model:
   fixed negative self-capacitance bug.
   Notes:
   - L_pin values in the Pin sections are loop inductance and
   include the mutual inductance to appropriate POWER/GND
   return paths.  POWER/GND parasitics are modeled in the
   Package Models.
   | IBIS Quality Specification 2.0 Summary
   | IQ Score: IQ3S
   | See Micron IBIS Model Quality Report and Quality Checklist
   | for full IQ details
[Disclaimer]  This software code and all associated documentation, comments
              or other information (collectively "Software") is provided
              "AS IS" without warranty of any kind. MICRON TECHNOLOGY, INC.
              ("MTI") EXPRESSLY DISCLAIMS ALL WARRANTIES EXPRESS OR IMPLIED,
              INCLUDING BUT NOT LIMITED TO, NONINFRINGEMENT OF THIRD PARTY
              RIGHTS, AND ANY IMPLIED WARRANTIES OF MERCHANTABILITY OR
              FITNESS FOR ANY PARTICULAR PURPOSE. MTI DOES NOT WARRANT THAT
              THE SOFTWARE WILL MEET YOUR REQUIREMENTS, OR THAT THE
              OPERATION OF THE SOFTWARE WILL BE UNINTERRUPTED OR ERROR-FREE.
              FURTHERMORE, MTI DOES NOT MAKE ANY REPRESENTATIONS REGARDING
              THE USE OR THE RESULTS OF THE USE OF THE SOFTWARE IN TERMS OF
              ITS CORRECTNESS, ACCURACY, RELIABILITY, OR OTHERWISE. THE
              ENTIRE RISK ARISING OUT OF USE OR PERFORMANCE OF THE SOFTWARE
              REMAINS WITH YOU. IN NO EVENT SHALL MTI, ITS AFFILIATED
              COMPANIES OR THEIR SUPPLIERS BE LIABLE FOR ANY DIRECT,
              INDIRECT, CONSEQUENTIAL, INCIDENTAL, OR SPECIAL DAMAGES
              (INCLUDING, WITHOUT LIMITATION, DAMAGES FOR LOSS OF PROFITS,
              BUSINESS INTERRUPTION, OR LOSS OF INFORMATION) ARISING OUT OF
              YOUR USE OF OR INABILITY TO USE THE SOFTWARE, EVEN IF MTI HAS
              BEEN ADVISED OF THE POSSIBILITY OF SUCH DAMAGES. Because some
              jurisdictions prohibit the exclusion or limitation of
              liability for consequential or incidental damages, the above
              limitation may not apply to you.
[Copyright]   Copyright 2013 Micron Technology, Inc. All rights reserved.
| COMPONENT: MTFCxGxCDM-1M
[Component]   MTFCxGxCDM-1M
[Manufacturer]   Micron Technology, Inc.
[Package]
| variable   typ   min   max
R_pkg   662.2m   396.9m   839.5m
L_pkg   5.228nH   3.189nH   6.984nH
C_pkg   2.113pF   1.350pF   2.520pF
[Package Model]  J54K_155U_153b_RLC_matrix
[Pin]   signal_name   model_name   R_pin   L_pin   C_pin
A1   NC   NC
A2   NC   NC
A3   DAT0   MICRO_DAT   763.6m   5.946nH   2.416pF
A4   DAT1   MICRO_DAT   740.6m   6.173nH   2.328pF
A5   DAT2   MICRO_DAT   839.5m   6.984nH   2.520pF
A6   NC   NC
A7   NC   NC
A8   NC   NC
A9   NC   NC
A10   NC   NC
A11   NC   NC
A12   NC   NC
A13   NC   NC
A14   NC   NC
B1   NC   NC
B2   DAT3   MICRO_DAT   769.4m   6.089nH   2.420pF
B3   DAT4   MICRO_DAT   701.2m   5.776nH   2.235pF
B4   DAT5   MICRO_DAT   685.7m   5.767nH   2.113pF
B5   DAT6   MICRO_DAT   677.5m   5.432nH   2.175pF
B6   DAT7   MICRO_DAT   662.2m   5.228nH   2.137pF
B7   NC   NC
B8   NC   NC
B9   NC   NC
B10   NC   NC
B11   NC   NC
B12   NC   NC
B13   NC   NC
B14   NC   NC
C1   NC   NC
C2   VDDI   POWER
C3   NC   NC
C4   VSSQ   GND
C5   NC   NC
C6   VCCQ2   POWER
C7   NC   NC
C8   NC   NC
C9   NC   NC
C10   NC   NC
C11   NC   NC
C12   NC   NC
C13   NC   NC
C14   NC   NC
D1   NC   NC
D2   NC   NC
D3   NC   NC
D4   NC   NC
D12   NC   NC
D13   NC   NC
D14   NC   NC
E1   NC   NC
E2   NC   NC
E3   NC   NC
E5   NC   NC
E6   VCC   POWER
E7   VSS   GND
E8   NC   NC
E9   NC   NC
E10   NC   NC
E12   NC   NC
E13   NC   NC
E14   NC   NC
F1   NC   NC
F2   NC   NC
F3   NC   NC
F5   VCC   POWER
F10   NC   NC
F12   NC   NC
F13   NC   NC
F14   NC   NC
G1   NC   NC
G2   NC   NC
G3   NC   NC
G5   VSS   GND
G10   NC   NC
G12   NC   NC
G13   NC   NC
G14   NC   NC
H1   NC   NC
H2   NC   NC
H3   NC   NC
H5   NC   NC
H10   VSS   GND
H12   NC   NC
H13   NC   NC
H14   NC   NC
J1   NC   NC
J2   NC   NC
J3   NC   NC
J5   NC   NC
J10   VCC   POWER
J12   NC   NC
J13   NC   NC
J14   NC   NC
K1   NC   NC
K2   NC   NC
K3   NC   NC
K5   RSTn   MICRO_IN2   485.5m   4.120nH   1.600pF
K6   NC   NC
K7   NC   NC
K8   VSS   GND
K9   VCC   POWER
K10   NC   NC
K12   NC   NC
K13   NC   NC
K14   NC   NC
L1   NC   NC
L2   NC   NC
L3   NC   NC
L12   NC   NC
L13   NC   NC
L14   NC   NC
M1   NC   NC
M2   NC   NC
M3   NC   NC
M4   VCCQ2   POWER
M5   CMD   MICRO_CMD   396.9m   3.189nH   1.447pF
M6   CLK   MICRO_IN   398.6m   3.351nH   1.350pF
M7   NC   NC
M8   NC   NC
M9   NC   NC
M10   NC   NC
M11   NC   NC
M12   NC   NC
M13   NC   NC
M14   NC   NC
N1   NC   NC
N2   VSSQ   GND
N3   NC   NC
N4   VCCQ1   POWER
N5   VSSQ   GND
N6   NC   NC
N7   NC   NC
N8   NC   NC
N9   NC   NC
N10   NC   NC
N11   NC   NC
N12   NC   NC
N13   NC   NC
N14   NC   NC
P1   NC   NC
P2   NC   NC
P3   VCCQ1   POWER
P4   VSSQ   GND
P5   VCCQ1   POWER
P6   VSSQ   GND
P7   NC   NC
P8   NC   NC
P9   NC   NC
P10   NC   NC
P11   NC   NC
P12   NC   NC
P13   NC   NC
P14   NC   NC
[Pin Mapping]   pulldown_ref  pullup_ref   gnd_clamp_ref power_clamp_ref
A1   NC   NC
A2   NC   NC
A3   VSSQ_net   VCCQ2_net
A4   VSSQ_net   VCCQ2_net
A5   VSSQ_net   VCCQ2_net
A6   NC   NC
A7   NC   NC
A8   NC   NC
A9   NC   NC
A10   NC   NC
A11   NC   NC
A12   NC   NC
A13   NC   NC
A14   NC   NC
B1   NC   NC
B2   VSSQ_net   VCCQ2_net
B3   VSSQ_net   VCCQ2_net
B4   VSSQ_net   VCCQ2_net
B5   VSSQ_net   VCCQ2_net
B6   VSSQ_net   VCCQ2_net
B7   NC   NC
B8   NC   NC
B9   NC   NC
B10   NC   NC
B11   NC   NC
B12   NC   NC
B13   NC   NC
B14   NC   NC
C1   NC   NC
C2   NC   VDDI_net
C3   NC   NC
C4   VSSQ_net   NC
C5   NC   NC
C6   NC   VCCQ2_net
C7   NC   NC
C8   NC   NC
C9   NC   NC
C10   NC   NC
C11   NC   NC
C12   NC   NC
C13   NC   NC
C14   NC   NC
D1   NC   NC
D2   NC   NC
D3   NC   NC
D4   NC   NC
D12   NC   NC
D13   NC   NC
D14   NC   NC
E1   NC   NC
E2   NC   NC
E3   NC   NC
E5   NC   NC
E6   NC   VCC_net
E7   VSS_forced   NC
E8   NC   NC
E9   NC   NC
E10   NC   NC
E12   NC   NC
E13   NC   NC
E14   NC   NC
F1   NC   NC
F2   NC   NC
F3   NC   NC
F5   NC   VCC_net
F10   NC   NC
F12   NC   NC
F13   NC   NC
F14   NC   NC
G1   NC   NC
G2   NC   NC
G3   NC   NC
G5   VSS_net   NC
G10   NC   NC
G12   NC   NC
G13   NC   NC
G14   NC   NC
H1   NC   NC
H2   NC   NC
H3   NC   NC
H5   NC   NC
H10   VSS_net   NC
H12   NC   NC
H13   NC   NC
H14   NC   NC
J1   NC   NC
J2   NC   NC
J3   NC   NC
J5   NC   NC
J10   NC   VCC_net
J12   NC   NC
J13   NC   NC
J14   NC   NC
K1   NC   NC
K2   NC   NC
K3   NC   NC
K5   NC   NC   VSSQ_net   VCCQ2_net
K6   NC   NC
K7   NC   NC
K8   VSS_net   NC
K9   NC   VCC_net
K10   NC   NC
K12   NC   NC
K13   NC   NC
K14   NC   NC
L1   NC   NC
L2   NC   NC
L3   NC   NC
L12   NC   NC
L13   NC   NC
L14   NC   NC
M1   NC   NC
M2   NC   NC
M3   NC   NC
M4   NC   VCCQ2_net
M5   VSSQ_net   VCCQ2_net
M6   NC   NC   VSSQ_net   VCCQ2_net
M7   NC   NC
M8   NC   NC
M9   NC   NC
M10   NC   NC
M11   NC   NC
M12   NC   NC
M13   NC   NC
M14   NC   NC
N1   NC   NC
N2   VSSQ_net   NC
N3   NC   NC
N4   NC   VCCQ1_net
N5   VSSQ_net   NC
N6   NC   NC
N7   NC   NC
N8   NC   NC
N9   NC   NC
N10   NC   NC
N11   NC   NC
N12   NC   NC
N13   NC   NC
N14   NC   NC
P1   NC   NC
P2   NC   NC
P3   NC   VCCQ1_net
P4   VSSQ_net   NC
P5   NC   VCCQ1_net
P6   VSSQ_net   NC
P7   NC   NC
P8   NC   NC
P9   NC   NC
P10   NC   NC
P11   NC   NC
P12   NC   NC
P13   NC   NC
P14   NC   NC
| COMPONENT: J54A_153b_11p5x13
[Component] J54A_153b_11p5x13
[Manufacturer] Micron Technology, Inc.
[Package]
| variable   typ   min   max
R_pkg   306.3m   203.6m   491.3m
L_pkg   2.880nH   1.969nH   4.506nH
C_pkg   1.741pF   1.139pF   3.063pF
[Package Model] J54A_153b_11p5x13_RLC_matrix
[Pin]   signal_name   model_name   R_pin   L_pin   C_pin
A1   NC   NC
A2   NC   NC
A3   DAT0   MICRO_DAT   224.5m   1.969nH   1.661pF
A4   DAT1   MICRO_DAT   203.6m   1.989nH   1.193pF
A5   DAT2   MICRO_DAT   232.3m   2.118nH   1.167pF
A6   NC   NC
A7   NC   NC
A8   NC   NC
A9   NC   NC
A10   NC   NC
A11   NC   NC
A12   NC   NC
A13   NC   NC
A14   NC   NC
B1   NC   NC
B2   DAT3   MICRO_DAT   291.1m   2.880nH   1.741pF
B3   DAT4   MICRO_DAT   255.9m   2.234nH   1.276pF
B4   DAT5   MICRO_DAT   306.3m   2.919nH   1.435pF
B5   DAT6   MICRO_DAT   254.8m   2.312nH   2.018pF
B6   DAT7   MICRO_DAT   257.7m   2.162nH   1.139pF
B7   NC   NC
B8   NC   NC
B9   NC   NC
B10   NC   NC
B11   NC   NC
B12   NC   NC
B13   NC   NC
B14   NC   NC
C1   NC   NC
C2   VDDI   POWER
C3   NC   NC
C4   VSS   GND
C5   NC   NC
C6   VCCQ2   POWER
C7   NC   NC
C8   NC   NC
C9   NC   NC
C10   NC   NC
C11   NC   NC
C12   NC   NC
C13   NC   NC
C14   NC   NC
D1   NC   NC
D2   NC   NC
D3   NC   NC
D4   NC   NC
D12   NC   NC
D13   NC   NC
D14   NC   NC
E1   NC   NC
E2   NC   NC
E3   NC   NC
E5   NC   NC
E6   VCCF   POWER
E7   NC   NC
E8   NC   NC
E9   NC   NC
E10   NC   NC
E12   NC   NC
E13   NC   NC
E14   NC   NC
F1   NC   NC
F2   NC   NC
F3   NC   NC
F5   VCCF   POWER
F10   NC   NC
F12   NC   NC
F13   NC   NC
F14   NC   NC
G1   NC   NC
G2   NC   NC
G3   NC   NC
G5   VSS   GND
G10   NC   NC
G12   NC   NC
G13   NC   NC
G14   NC   NC
H1   NC   NC
H2   NC   NC
H3   NC   NC
H5   NC   NC
H10   VSS   GND
H12   NC   NC
H13   NC   NC
H14   NC   NC
J1   NC   NC
J2   NC   NC
J3   NC   NC
J5   NC   NC
J10   VCCF   POWER
J12   NC   NC
J13   NC   NC
J14   NC   NC
K1   NC   NC
K2   NC   NC
K3   NC   NC
K5   RST_n   MICRO_IN2   471.9m   4.186nH   1.992pF
K6   NC   NC
K7   NC   NC
K8   VSS   GND
K9   VCCF   POWER
K10   NC   NC
K12   NC   NC
K13   NC   NC
K14   NC   NC
L1   NC   NC
L2   NC   NC
L3   NC   NC
L12   NC   NC
L13   NC   NC
L14   NC   NC
M1   NC   NC
M2   NC   NC
M3   NC   NC
M4   VCCQ2   POWER
M5   CMD   MICRO_CMD   491.3m   4.506nH   3.063pF
M6   CLK   MICRO_IN   470.0m   4.503nH   2.090pF
M7   NC   NC
M8   NC   NC
M9   NC   NC
M10   NC   NC
M11   NC   NC
M12   NC   NC
M13   NC   NC
M14   NC   NC
N1   NC   NC
N2   GNDA   GND
N3   NC   NC
N4   VCCQ1   POWER
N5   GNDA   GND
N6   NC   NC
N7   NC   NC
N8   NC   NC
N9   NC   NC
N10   NC   NC
N11   NC   NC
N12   NC   NC
N13   NC   NC
N14   NC   NC
P1   NC   NC
P2   NC   NC
P3   VCCQ1   POWER
P4   GNDA   GND
P5   VCCQ1   POWER
P6   GNDA   GND
P7   NC   NC
P8   NC   NC
P9   NC   NC
P10   NC   NC
P11   NC   NC
P12   NC   NC
P13   NC   NC
P14   NC   NC
[Pin Mapping]   pulldown_ref  pullup_ref   gnd_clamp_ref power_clamp_ref
A1   NC   NC
A2   NC   NC
A3   VSS_glob   VCCQ2_net
A4   VSS_glob   VCCQ2_net
A5   VSS_glob   VCCQ2_net
A6   NC   NC
A7   NC   NC
A8   NC   NC
A9   NC   NC
A10   NC   NC
A11   NC   NC
A12   NC   NC
A13   NC   NC
A14   NC   NC
B1   NC   NC
B2   VSS_glob   VCCQ2_net
B3   VSS_glob   VCCQ2_net
B4   VSS_glob   VCCQ2_net
B5   VSS_glob   VCCQ2_net
B6   VSS_glob   VCCQ2_net
B7   NC   NC
B8   NC   NC
B9   NC   NC
B10   NC   NC
B11   NC   NC
B12   NC   NC
B13   NC   NC
B14   NC   NC
C1   NC   NC
C2   NC   VDDI_net
C3   NC   NC
C4   VSS_glob   NC
C5   NC   NC
C6   NC   VCCQ2_net
C7   NC   NC
C8   NC   NC
C9   NC   NC
C10   NC   NC
C11   NC   NC
C12   NC   NC
C13   NC   NC
C14   NC   NC
D1   NC   NC
D2   NC   NC
D3   NC   NC
D4   NC   NC
D12   NC   NC
D13   NC   NC
D14   NC   NC
E1   NC   NC
E2   NC   NC
E3   NC   NC
E5   NC   NC
E6   NC   VCCF_net
E7   NC   NC
E8   NC   NC
E9   NC   NC
E10   NC   NC
E12   NC   NC
E13   NC   NC
E14   NC   NC
F1   NC   NC
F2   NC   NC
F3   NC   NC
F5   NC   VCCF_net
F10   NC   NC
F12   NC   NC
F13   NC   NC
F14   NC   NC
G1   NC   NC
G2   NC   NC
G3   NC   NC
G5   VSS_glob   NC
G10   NC   NC
G12   NC   NC
G13   NC   NC
G14   NC   NC
H1   NC   NC
H2   NC   NC
H3   NC   NC
H5   NC   NC
H10   VSS_glob   NC
H12   NC   NC
H13   NC   NC
H14   NC   NC
J1   NC   NC
J2   NC   NC
J3   NC   NC
J5   NC   NC
J10   NC   VCCF_net
J12   NC   NC
J13   NC   NC
J14   NC   NC
K1   NC   NC
K2   NC   NC
K3   NC   NC
K5   NC   NC   VSS_glob   VCCQ2_net
K6   NC   NC
K7   NC   NC
K8   VSS_glob   NC
K9   NC   VCCF_net
K10   NC   NC
K12   NC   NC
K13   NC   NC
K14   NC   NC
L1   NC   NC
L2   NC   NC
L3   NC   NC
L12   NC   NC
L13   NC   NC
L14   NC   NC
M1   NC   NC
M2   NC   NC
M3   NC   NC
M4   NC   VCCQ2_net
M5   VSS_glob   VCCQ2_net
M6   NC   NC   VSS_glob   VCCQ2_net
M7   NC   NC
M8   NC   NC
M9   NC   NC
M10   NC   NC
M11   NC   NC
M12   NC   NC
M13   NC   NC
M14   NC   NC
N1   NC   NC
N2   GND_net   NC
N3   NC   NC
N4   NC   VCCQ1_net
N5   GND_net   NC
N6   NC   NC
N7   NC   NC
N8   NC   NC
N9   NC   NC
N10   NC   NC
N11   NC   NC
N12   NC   NC
N13   NC   NC
N14   NC   NC
P1   NC   NC
P2   NC   NC
P3   NC   VCCQ1_net
P4   GND_net   NC
P5   NC   VCCQ1_net
P6   GND_net   NC
P7   NC   NC
P8   NC   NC
P9   NC   NC
P10   NC   NC
P11   NC   NC
P12   NC   NC
P13   NC   NC
P14   NC   NC
| COMPONENT: J56W_169b
[Component]   J56W_169b
[Manufacturer]   Micron Technology, Inc.
[Package]
| variable   typ   min   max
R_pkg   401.1m   330.2m   610.4m
L_pkg   3.519nH   2.727nH   4.863nH
C_pkg   2.276pF   1.491pF   3.090pF
[Package Model]  J56W_169b_RLC_matrix
[Pin]   signal_name   model_name   R_pin   L_pin   C_pin
A4   NC   NC
A6   NC   NC
A9   NC   NC
A11   NC   NC
B2   NC   NC
B13   NC   NC
D1   NC   NC
D14   NC   NC
H1   NC   NC
H2   NC   NC
H3   DAT0   MICRO_DAT   332.8m   2.834nH   2.126pF
H4   DAT1   MICRO_DAT   333.6m   2.859nH   1.491pF
H5   DAT2   MICRO_DAT   349.9m   2.977nH   2.296pF
H6   NC   NC
H7   NC   NC
H8   NC   NC
H9   NC   NC
H10   NC   NC
H11   NC   NC
H12   NC   NC
H13   NC   NC
H14   NC   NC
J1   NC   NC
J2   DAT3   MICRO_DAT   401.1m   3.519nH   1.555pF
J3   DAT4   MICRO_DAT   380.4m   3.271nH   2.276pF
J4   DAT5   MICRO_DAT   364.1m   3.154nH   2.324pF
J5   DAT6   MICRO_DAT   354.5m   3.001nH   2.391pF
J6   DAT7   MICRO_DAT   330.2m   2.727nH   2.611pF
J7   NC   NC
J8   NC   NC
J9   NC   NC
J10   NC   NC
J11   NC   NC
J12   NC   NC
J13   NC   NC
J14   NC   NC
K1   NC   NC
K2   VDDI   POWER
K3   NC   NC
K4   VSS   GND
K5   NC   NC
K6   VCCQ2   POWER
K7   NC   NC
K8   NC   NC
K9   NC   NC
K10   NC   NC
K11   NC   NC
K12   NC   NC
K13   NC   NC
K14   NC   NC
L1   NC   NC
L2   NC   NC
L3   NC   NC
L4   NC   NC
L12   NC   NC
L13   NC   NC
L14   NC   NC
M1   NC   NC
M2   NC   NC
M3   NC   NC
M5   NC   NC
M6   VCC   POWER
M7   VSS2   GND
M8   NC   NC
M9   NC   NC
M10   NC   NC
M12   NC   NC
M13   NC   NC
M14   NC   NC
N1   NC   NC
N2   NC   NC
N3   NC   NC
N5   VCC   POWER
N10   NC   NC
N12   NC   NC
N13   NC   NC
N14   NC   NC
P1   NC   NC
P2   NC   NC
P3   NC   NC
P5   VSS   GND
P10   NC   NC
P12   NC   NC
P13   NC   NC
P14   NC   NC
R1   NC   NC
R2   NC   NC
R3   NC   NC
R5   NC   NC
R10   VSS   GND
R12   NC   NC
R13   NC   NC
R14   NC   NC
T1   NC   NC
T2   NC   NC
T3   NC   NC
T5   NC   NC
T10   VCC   POWER
T12   NC   NC
T13   NC   NC
T14   NC   NC
U1   NC   NC
U2   NC   NC
U3   NC   NC
U5   RSTn   MICRO_IN2   595.6m   4.863nH   3.090pF
U6   NC   NC
U7   NC   NC
U8   VSS   GND
U9   VCC   POWER
U10   NC   NC
U12   NC   NC
U13   NC   NC
U14   NC   NC
V1   NC   NC
V2   NC   NC
V3   NC   NC
V12   NC   NC
V13   NC   NC
V14   NC   NC
W1   NC   NC
W2   NC   NC
W3   NC   NC
W4   VCCQ2   POWER
W5   CMD   MICRO_CMD   610.4m   4.828nH   2.280pF
W6   CLK   MICRO_IN   581.7m   4.737nH   2.166pF
W7   NC   NC
W8   NC   NC
W9   NC   NC
W10   NC   NC
W11   NC   NC
W12   NC   NC
W13   NC   NC
W14   NC   NC
Y1   NC   NC
Y2   GNDA   GND
Y3   NC   NC
Y4   VCCQ1   POWER
Y5   GNDA   GND
Y6   NC   NC
Y7   NC   NC
Y8   NC   NC
Y9   NC   NC
Y10   NC   NC
Y11   NC   NC
Y12   NC   NC
Y13   NC   NC
Y14   NC   NC
AA1   NC   NC
AA2   NC   NC
AA3   VCCQ1   POWER
AA4   GNDA   GND
AA5   VCCQ1   POWER
AA6   GNDA   GND
AA7   NC   NC
AA8   NC   NC
AA9   NC   NC
AA10   NC   NC
AA11   NC   NC
AA12   NC   NC
AA13   NC   NC
AA14   NC   NC
AE1   NC   NC
AE14   NC   NC
AG2   NC   NC
AG13   NC   NC
AH4   NC   NC
AH6   NC   NC
AH9   NC   NC
AH11   NC   NC
[Pin Mapping]   pulldown_ref  pullup_ref   gnd_clamp_ref power_clamp_ref
A4   NC   NC
A6   NC   NC
A9   NC   NC
A11   NC   NC
B2   NC   NC
B13   NC   NC
D1   NC   NC
D14   NC   NC
H1   NC   NC
H2   NC   NC
H3   VSS_glob   VCCQ2_net
H4   VSS_glob   VCCQ2_net
H5   VSS_glob   VCCQ2_net
H6   NC   NC
H7   NC   NC
H8   NC   NC
H9   NC   NC
H10   NC   NC
H11   NC   NC
H12   NC   NC
H13   NC   NC
H14   NC   NC
J1   NC   NC
J2   VSS_glob   VCCQ2_net
J3   VSS_glob   VCCQ2_net
J4   VSS_glob   VCCQ2_net
J5   VSS_glob   VCCQ2_net
J6   VSS_glob   VCCQ2_net
J7   NC   NC
J8   NC   NC
J9   NC   NC
J10   NC   NC
J11   NC   NC
J12   NC   NC
J13   NC   NC
J14   NC   NC
K1   NC   NC
K2   NC   VDDI_net
K3   NC   NC
K4   VSS_glob   NC
K5   NC   NC
K6   NC   VCCQ2_net
K7   NC   NC
K8   NC   NC
K9   NC   NC
K10   NC   NC
K11   NC   NC
K12   NC   NC
K13   NC   NC
K14   NC   NC
L1   NC   NC
L2   NC   NC
L3   NC   NC
L4   NC   NC
L12   NC   NC
L13   NC   NC
L14   NC   NC
M1   NC   NC
M2   NC   NC
M3   NC   NC
M5   NC   NC
M6   NC   VCC_net
M7   VSS2_net   NC
M8   NC   NC
M9   NC   NC
M10   NC   NC
M12   NC   NC
M13   NC   NC
M14   NC   NC
N1   NC   NC
N2   NC   NC
N3   NC   NC
N5   NC   VCC_net
N10   NC   NC
N12   NC   NC
N13   NC   NC
N14   NC   NC
P1   NC   NC
P2   NC   NC
P3   NC   NC
P5   VSS_glob   NC
P10   NC   NC
P12   NC   NC
P13   NC   NC
P14   NC   NC
R1   NC   NC
R2   NC   NC
R3   NC   NC
R5   NC   NC
R10   VSS_glob   NC
R12   NC   NC
R13   NC   NC
R14   NC   NC
T1   NC   NC
T2   NC   NC
T3   NC   NC
T5   NC   NC
T10   NC   VCC_net
T12   NC   NC
T13   NC   NC
T14   NC   NC
U1   NC   NC
U2   NC   NC
U3   NC   NC
U5   VSS_glob   VCCQ2_net
U6   NC   NC
U7   NC   NC
U8   VSS_glob   NC
U9   NC   VCC_net
U10   NC   NC
U12   NC   NC
U13   NC   NC
U14   NC   NC
V1   NC   NC
V2   NC   NC
V3   NC   NC
V12   NC   NC
V13   NC   NC
V14   NC   NC
W1   NC   NC
W2   NC   NC
W3   NC   NC
W4   NC   VCCQ2_net
W5   VSS_glob   VCCQ2_net
W6   NC   NC   VSS_glob   VCCQ2_net
W7   NC   NC
W8   NC   NC
W9   NC   NC
W10   NC   NC
W11   NC   NC
W12   NC   NC
W13   NC   NC
W14   NC   NC
Y1   NC   NC
Y2   GND_net   NC
Y3   NC   NC
Y4   NC   VCCQ1_net
Y5   GND_net   NC
Y6   NC   NC
Y7   NC   NC
Y8   NC   NC
Y9   NC   NC
Y10   NC   NC
Y11   NC   NC
Y12   NC   NC
Y13   NC   NC
Y14   NC   NC
AA1   NC   NC
AA2   NC   NC
AA3   NC   VCCQ1_net
AA4   GND_net   NC
AA5   NC   VCCQ1_net
AA6   GND_net   NC
AA7   NC   NC
AA8   NC   NC
AA9   NC   NC
AA10   NC   NC
AA11   NC   NC
AA12   NC   NC
AA13   NC   NC
AA14   NC   NC
AE1   NC   NC
AE14   NC   NC
AG2   NC   NC
AG13   NC   NC
AH4   NC   NC
AH6   NC   NC
AH9   NC   NC
AH11   NC   NC
[Model Selector]   MICRO_DAT
DAT_1p8_3x_45_ohm   push-pull 45 ohm driver  - DSR=0x4000 (1.8V default)
DAT_1p8_1x_136_ohm  push-pull 136 ohm driver - DSR=0x0100
DAT_1p8_2x_68_ohm   push-pull 68 ohm driver  - DSR=0x0200
DAT_1p8_4x_34_ohm   push-pull 34 ohm driver  - DSR=0x0800
DAT_1p8_5x_27_ohm   push-pull 27 ohm driver  - DSR=0x1000
DAT_1p8_6x_23_ohm   push-pull 23 ohm driver  - DSR=0x2000
DAT_1p8_7x_19_ohm   push-pull 19 ohm driver  - DSR=0x4000
DAT_1p8_8x_17_ohm   push-pull 17 ohm driver  - DSR=0x8000
DAT_3p3_2x_41_ohm   push-pull 41 ohm driver  - DSR=0x0200 (3.3V default)
DAT_3p3_1x_83_ohm   push-pull 83 ohm driver  - DSR=0x0100
DAT_3p3_3x_28_ohm   push-pull 28 ohm driver  - DSR=0x0400
DAT_3p3_4x_21_ohm   push-pull 21 ohm driver  - DSR=0x0800
DAT_3p3_5x_17_ohm   push-pull 17 ohm driver  - DSR=0x1000
DAT_3p3_6x_14_ohm   push-pull 14 ohm driver  - DSR=0x2000
DAT_3p3_7x_12_ohm   push-pull 12 ohm driver  - DSR=0x4000
DAT_3p3_8x_10_ohm   push-pull 10 ohm driver  - DSR=0x8000
[Model Selector]   MICRO_CMD
CMD_1p8_3x_45_ohm   push-pull 45 ohm driver  - DSR=0x4000 (1.8V default)
CMD_1p8_1x_136_ohm  push-pull 136 ohm driver - DSR=0x0100
CMD_1p8_2x_68_ohm   push-pull 68 ohm driver  - DSR=0x0200
CMD_1p8_4x_34_ohm   push-pull 34 ohm driver  - DSR=0x0800
CMD_1p8_5x_27_ohm   push-pull 27 ohm driver  - DSR=0x1000
CMD_1p8_6x_23_ohm   push-pull 23 ohm driver  - DSR=0x2000
CMD_1p8_7x_19_ohm   push-pull 19 ohm driver  - DSR=0x4000
CMD_1p8_8x_17_ohm   push-pull 17 ohm driver  - DSR=0x8000
CMD_3p3_2x_41_ohm   push-pull 41 ohm driver  - DSR=0x0200 (3.3V default)
CMD_3p3_1x_83_ohm   push-pull 83 ohm driver  - DSR=0x0100
CMD_3p3_3x_28_ohm   push-pull 28 ohm driver  - DSR=0x0400
CMD_3p3_4x_21_ohm   push-pull 21 ohm driver  - DSR=0x0800
CMD_3p3_5x_17_ohm   push-pull 17 ohm driver  - DSR=0x1000
CMD_3p3_6x_14_ohm   push-pull 14 ohm driver  - DSR=0x2000
CMD_3p3_7x_12_ohm   push-pull 12 ohm driver  - DSR=0x4000
CMD_3p3_8x_10_ohm   push-pull 10 ohm driver  - DSR=0x8000
[Model Selector]   MICRO_IN
MICRO_IN_1p8   1.8V CLK buffer
MICRO_IN_3p3   3.3V CLK buffer
[Model Selector]   MICRO_IN2
MICRO_IN2_1p8   1.8V RST buffer
MICRO_IN2_3p3   3.3V RST buffer
[Define Package Model] J54K_155U_153b_RLC_matrix
[Manufacturer] Micron Technology, Inc.
[OEM] Micron Technology, Inc.
[Description] 153 balls - 11.5x13x1.2
[Number of Pins] 18
[Pin Numbers]
A3  | DAT0
A4  | DAT1
A5  | DAT2
B2  | DAT3
B3  | DAT4
B4  | DAT5
B5  | DAT6
B6  | DAT7
C2  | VDDI
C4  | VSSQ
C6  | VCCQ2
E6  | VCC
E7  | VSS
G5  | VSS
K5  | RST_n
M5  | CMD
M6  | CLK
N4  | VCCQ1
[Model Data]
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[End Model Data]
[End Package Model]
[Define Package Model] J54A_153b_11p5x13_RLC_matrix
[Manufacturer] Micron Technology, Inc.
[OEM] Micron Technology, Inc.
[Description] 153 balls - 11.5 x 13 mm
[Number of Pins] 17
[Pin Numbers]
A3  | DAT0
A4  | DAT1
A5  | DAT2
B2  | DAT3
B3  | DAT4
B4  | DAT5
B5  | DAT6
B6  | DAT7
C2  | VDDI
C4  | VSS
C6  | VCCQ2
E6  | VCC
K5  | RST_n
M5  | CMD
M6  | CLK
N2  | GNDA
N4  | VCCQ1
[Model Data]
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[End Model Data]
[End Package Model]
[Define Package Model] J56W_169b_RLC_matrix
[Manufacturer] Micron Technology, Inc.
[OEM] Micron Technology, Inc.
[Description] 169 balls - 12 x 16 x 1.0 mm VFBGA
[Number of Pins] 17
[Pin Numbers]
H3  | DAT0
H4  | DAT1
H5  | DAT2
J2  | DAT3
J3  | DAT4
J4  | DAT5
J5  | DAT6
J6  | DAT7
K2  | VDDI
K4  | VSS
K6  | VCCQ2
M6  | VCC
U5  | RST_n
W5  | CMD
W6  | CLK
Y2  | GNDA
Y4  | VCCQ1
[Model Data]
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[End Model Data]
[End Package Model]
| Models and submodels in the file (36): MICRO_IN_1p8 (Input), MICRO_IN2_1p8 (Input), DAT_1p8_1x_136_ohm (I/O), DAT_1p8_2x_68_ohm (I/O), DAT_1p8_3x_45_ohm (I/O), DAT_1p8_4x_34_ohm (I/O), DAT_1p8_5x_27_ohm (I/O), DAT_1p8_6x_23_ohm (I/O), DAT_1p8_7x_19_ohm (I/O), DAT_1p8_8x_17_ohm (I/O), CMD_1p8_1x_136_ohm (I/O), CMD_1p8_2x_68_ohm (I/O), CMD_1p8_3x_45_ohm (I/O), CMD_1p8_4x_34_ohm (I/O), CMD_1p8_5x_27_ohm (I/O), CMD_1p8_6x_23_ohm (I/O), CMD_1p8_7x_19_ohm (I/O), CMD_1p8_8x_17_ohm (I/O), MICRO_IN_3p3 (Input), MICRO_IN2_3p3 (Input), DAT_3p3_1x_83_ohm (I/O), DAT_3p3_2x_41_ohm (I/O), DAT_3p3_3x_28_ohm (I/O), DAT_3p3_4x_21_ohm (I/O), DAT_3p3_5x_17_ohm (I/O), DAT_3p3_6x_14_ohm (I/O), DAT_3p3_7x_12_ohm (I/O), DAT_3p3_8x_10_ohm (I/O), CMD_3p3_1x_83_ohm (I/O), CMD_3p3_2x_41_ohm (I/O), CMD_3p3_3x_28_ohm (I/O), CMD_3p3_4x_21_ohm (I/O), CMD_3p3_5x_17_ohm (I/O), CMD_3p3_6x_14_ohm (I/O), CMD_3p3_7x_12_ohm (I/O), CMD_3p3_8x_10_ohm (I/O)
