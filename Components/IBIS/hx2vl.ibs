| IBIS file hx2vl.ibs
[IBIS ver]   4.1
[File name]   hx2vl.ibs
[File Rev]   1.0
|[Device name] HX2VL: part number CY7C65632/34/42
[Date]   2012/02/22 03:35:25 PM
[Source]   File created by Cypress Semiconductor
[Notes]
CONTENTS
This is the IBIS model for Cypress part CY7C65632/34/42
This is the low-power version of Cypress's USB 2 compliant Hub.
VERIFICATION
This model was syntax checked with Hyperlynx 4.1 visual IBIS editor.
There are several monotonicity warnings in this file due to the subtraction of
the clamp data from the pullup/pulldown curves; this result is expected.
The USB ground clamp data has extreme current warnings in this file; system
simulation run and passed to ensure this doesn't cause any issues.
VERSION HISTORY
1.0 - 2012 February 22 Generated HX2VL IBIS model
 Silicon Model Information
 **All silicon based measurements were performed on TYPICAL silicon. MIN and
 MAX values represent +/-20% of the TYPICAL silicon measurement****
 Pullup and Pulldown curves still have the simulation based clamp data in them
 Reference resistor RREF = 650ohm
QUESTIONS?
 If there are any additional questions or concerns about using this
 "model," please create a technical support case at www.cypress.com/support
 or call the technical support line at 1-800-541-4736 option 8
[Copyright]   Copyright of Cypress Semiconductor Corporation, all rights reserved
[Disclaimer]   This information is for IBIS modeling purposes only, and is not
   guaranteed
|   Component CY7C65642_48TQFP
[Component]   CY7C65642_48TQFP
[Manufacturer]  Cypress Semiconductor
[Package]
| variable   typ   min   max
R_pkg   69.10m   58.50m   79.60m
L_pkg   3.10nH   2.00nH   4.20nH
C_pkg   0.34pF   0.19pF   0.49pF
|-------------------------PIN------------------------------------------------
[Pin]  signal_name   model_name   R_pin   L_pin   C_pin
1   AVDD2   POWER
2   AGND2   GND
3   DM   usb_dm   0   0   0
4   DP   usb_dp   0   0   0
5   DDM1   usb_dm
6   DDP1   usb_dp
7   AVDD   POWER
8   AGND   GND
9   DDM2   usb_dm
10   DDP2   usb_dp
11   RREF   POWER
12   AVDD1   POWER
13   AGND1   GND
14   XIN   xtal_in   0   0   0
15   XOUT   xtal_out   0   0   0
16   AVDD   POWER
17   DDM3   usb_dm
18   DDP3   usb_dp
19   AVDD   POWER
20   AGND   GND
21   DDM4   usb_dm
22   DDP4   usb_dp
23   GREEN4   gpio1   0   0   0
24   AMBER4   gpio1
25   SEL48   input3   0   0   0
26   RESET_N   input2   0   0   0
27   SCL   gpio1
28   OVCUR4   input4   0   0   0
29   PWREN4   gpio5   0   0   0
30   OVCUR3   input4
31   PWREN3   gpio5
32   GREEN3   gpio1
33   AMBER3   gpio1
34   VDD33   POWER
35   GREEN2   gpio1
36   AMBER2   gpio1
37   SELFPWR   input1   0   0   0
38   DVDD   POWER
39   GANG   gpio5
40   OVCUR2   input4
41   PWREN2   gpio5
42   OVCUR1   input4
43   PWREN1   gpio5
44   SEL27   input3
45   GREEN1   gpio1
46   AMBER1   gpio1
47   V5   POWER
48   V33   POWER
|-------------------------DIFF PIN------------------------------------------
[Diff_pin]   inv_pin   vdiff   tdelay_typ   tdelay_min   tdelay_max
  10   9   200mV   NA   NA   NA
  18   17   200mV   NA   NA   NA
  22   21   200mV   NA   NA   NA
  4   3   200mV   NA   NA   NA
  6   5   200mV   NA   NA   NA
|   Component CY7C65632_48TQFP
[Component]   CY7C65632_48TQFP
[Manufacturer]  Cypress Semiconductor
[Package]
| variable   typ   min   max
R_pkg   69.10m   58.50m   79.60m
L_pkg   3.10nH   2.00nH   4.20nH
C_pkg   0.34pF   0.19pF   0.49pF
|-------------------------PIN------------------------------------------------
[Pin]  signal_name   model_name   R_pin   L_pin   C_pin
1   AVDD2   POWER
2   AGND2   GND
3   DM   usb_dm   0   0   0
4   DP   usb_dp   0   0   0
5   DDM1   usb_dm
6   DDP1   usb_dp
7   AVDD   POWER
8   AGND   GND
9   DDM2   usb_dm
10   DDP2   usb_dp
11   RREF   POWER
12   AVDD1   POWER
13   AGND1   GND
14   XIN   xtal_in   0   0   0
15   XOUT   xtal_out   0   0   0
16   AVDD   POWER
17   DDM3   usb_dm
18   DDP3   usb_dp
19   AVDD   POWER
20   AGND   GND
21   DDM4   usb_dm
22   DDP4   usb_dp
23   GREEN4   gpio1   0   0   0
24   AMBER4   gpio1
25   SEL48   input3   0   0   0
26   RESET_N   input2   0   0   0
27   SCL   gpio1
28   OVCUR4   input4   0   0   0
29   PWREN4   gpio5   0   0   0
30   OVCUR3   input4
31   PWREN3   gpio5
32   GREEN3   gpio1
33   AMBER3   gpio1
34   VDD33   POWER
35   GREEN2   gpio1
36   AMBER2   gpio1
37   SELFPWR   input1   0   0   0
38   DVDD   POWER
39   GANG   gpio5
40   OVCUR2   input4
41   PWREN2   gpio5
42   OVCUR1   input4
43   PWREN1   gpio5
44   SEL27   input3
45   GREEN1   gpio1
46   AMBER1   gpio1
47   V5   POWER
48   V33   POWER
|-------------------------DIFF PIN------------------------------------------
[Diff_pin]   inv_pin   vdiff   tdelay_typ   tdelay_min   tdelay_max
  10   9   200mV   NA   NA   NA
  18   17   200mV   NA   NA   NA
  22   21   200mV   NA   NA   NA
  4   3   200mV   NA   NA   NA
  6   5   200mV   NA   NA   NA
|   Component CY7C65634_48TQFP
[Component]   CY7C65634_48TQFP
[Manufacturer]  Cypress Semiconductor
[Package]
| variable   typ   min   max
R_pkg   69.10m   58.50m   79.60m
L_pkg   3.10nH   2.00nH   4.20nH
C_pkg   0.34pF   0.19pF   0.49pF
|-------------------------PIN------------------------------------------------
[Pin]  signal_name   model_name   R_pin   L_pin   C_pin
1   AVDD2   POWER
2   AGND2   GND
3   DM   usb_dm   0   0   0
4   DP   usb_dp   0   0   0
5   DDM1   usb_dm
6   DDP1   usb_dp
7   AVDD   POWER
8   AGND   GND
9   DDM2   usb_dm
10   DDP2   usb_dp
11   RREF   POWER
12   AVDD1   POWER
13   AGND1   GND
14   XIN   xtal_in   0   0   0
15   XOUT   xtal_out   0   0   0
16   AVDD   POWER
17   DDM3   NC
18   DDP3   NC
19   AVDD   NC
20   AGND   GND
21   DDM4   NC
22   DDP4   NC
23   GREEN4   NC
24   AMBER4   NC
25   SEL48   input3   0   0   0
26   RESET_N   input2   0   0   0
27   SCL   gpio1
28   OVCUR4   NC
29   PWREN4   NC
30   OVCUR3   NC
31   PWREN3   NC
32   GREEN3   NC
33   AMBER3   NC
34   VDD33   POWER
35   GREEN2   gpio1
36   AMBER2   gpio1
37   SELFPWR   input1   0   0   0
38   DVDD   POWER
39   GANG   gpio5
40   OVCUR2   input4
41   PWREN2   gpio5
42   OVCUR1   input4
43   PWREN1   gpio5
44   SEL27   input3
45   GREEN1   gpio1
46   AMBER1   gpio1
47   V5   POWER
48   V33   POWER
|-------------------------DIFF PIN------------------------------------------
[Diff_pin]   inv_pin   vdiff   tdelay_typ   tdelay_min   tdelay_max
  10   9   200mV   NA   NA   NA
  4   3   200mV   NA   NA   NA
  6   5   200mV   NA   NA   NA
|   Component CY7C65642_28QFN
[Component]   CY7C65642_28QFN
[Manufacturer]  Cypress Semiconductor
[Package]
| variable   typ   min   max
R_pkg   38.5m   34.6m   42.3m
L_pkg   4.27nH   3.84nH   4.7nH
C_pkg   0.85pF   0.76pF   0.935pF
|-------------------------PIN------------------------------------------------
[Pin]  signal_name   model_name   R_pin   L_pin   C_pin
1   DM   usb_dm   0   0   0
2   DP   usb_dp   0   0   0
3   DDM1   usb_dm
4   DDP1   usb_dp
5   AVDD   POWER
6   DDM2   usb_dm
7   DDP2   usb_dp
8   RREF   POWER
9   AVDD1   POWER
10   XIN   xtal_in   0   0   0
11   XOUT   xtal_out   0   0   0
12   DDM3   usb_dm
13   DDP3   usb_dp
14   AVDD   POWER
15   DDM4   usb_dm
16   DDP4   usb_dp
17   RESET_N   input2   0   0   0
18   SCL   gpio1
19   OVCUR4   input4   0   0   0
20   OVCUR3   input4
21   VDD33   POWER
22   SELFPWR   input1   0   0   0
23   GANG   gpio5
24   OVCUR2   input4
25   OVCUR1   input4
43   PWREN1   gpio5
47   V5   POWER
48   V33   POWER
|-------------------------DIFF PIN------------------------------------------
[Diff_pin]   inv_pin   vdiff   tdelay_typ   tdelay_min   tdelay_max
  7   6   200mV   NA   NA   NA
  13   12   200mV   NA   NA   NA
  16   15   200mV   NA   NA   NA
  2   1   200mV   NA   NA   NA
  4   3   200mV   NA   NA   NA
|   Component CY7C65632_28QFN
[Component]   CY7C65632_28QFN
[Manufacturer]  Cypress Semiconductor
[Package]
| variable   typ   min   max
R_pkg   38.5m   34.6m   42.3m
L_pkg   4.27nH   3.84nH   4.7nH
C_pkg   0.85pF   0.76pF   0.935pF
|-------------------------PIN------------------------------------------------
[Pin]  signal_name   model_name   R_pin   L_pin   C_pin
1   DM   usb_dm   0   0   0
2   DP   usb_dp   0   0   0
3   DDM1   usb_dm
4   DDP1   usb_dp
5   AVDD   POWER
6   DDM2   usb_dm
7   DDP2   usb_dp
8   RREF   POWER
9   AVDD1   POWER
10   XIN   xtal_in   0   0   0
11   XOUT   xtal_out   0   0   0
12   DDM3   usb_dm
13   DDP3   usb_dp
14   AVDD   POWER
15   DDM4   usb_dm
16   DDP4   usb_dp
17   RESET_N   input2   0   0   0
18   SCL   gpio1
19   OVCUR4   input4   0   0   0
20   OVCUR3   input4
21   VDD33   POWER
22   SELFPWR   input1   0   0   0
23   GANG   gpio5
24   OVCUR2   input4
25   OVCUR1   input4
43   PWREN1   gpio5
47   V5   POWER
48   V33   POWER
|-------------------------DIFF PIN------------------------------------------
[Diff_pin]   inv_pin   vdiff   tdelay_typ   tdelay_min   tdelay_max
  7   6   200mV   NA   NA   NA
  13   12   200mV   NA   NA   NA
  16   15   200mV   NA   NA   NA
  2   1   200mV   NA   NA   NA
  4   3   200mV   NA   NA   NA
|   Component CY7C65634_28QFN
[Component]   CY7C65634_28QFN
[Manufacturer]  Cypress Semiconductor
[Package]
| variable   typ   min   max
R_pkg   38.5m   34.6m   42.3m
L_pkg   4.27nH   3.84nH   4.7nH
C_pkg   0.85pF   0.76pF   0.935pF
|-------------------------PIN------------------------------------------------
[Pin]  signal_name   model_name   R_pin   L_pin   C_pin
1   DM   usb_dm   0   0   0
2   DP   usb_dp   0   0   0
3   DDM1   usb_dm
4   DDP1   usb_dp
5   AVDD   POWER
6   DDM2   usb_dm
7   DDP2   usb_dp
8   RREF   POWER
9   AVDD1   POWER
10   XIN   xtal_in   0   0   0
11   XOUT   xtal_out   0   0   0
12   DDM3   NC
13   DDP3   NC
14   AVDD   POWER
15   DDM4   NC
16   DDP4   NC
17   RESET_N   input2   0   0   0
18   SCL   gpio1
19   OVCUR4   NC
20   OVCUR3   NC
21   VDD33   POWER
22   SELFPWR   input1   0   0   0
23   GANG   gpio5
24   OVCUR2   input4
25   OVCUR1   input4
43   PWREN1   gpio5
47   V5   POWER
48   V33   POWER
|-------------------------DIFF PIN------------------------------------------
[Diff_pin]   inv_pin   vdiff   tdelay_typ   tdelay_min   tdelay_max
  7   6   200mV   NA   NA   NA
  2   1   200mV   NA   NA   NA
  4   3   200mV   NA   NA   NA
| Models and submodels in the file (10): xtal_in (Input), xtal_out (Output), gpio5 (I/O), input1 (Input), gpio1 (I/O), input2 (Input), input3 (Input), input4 (Input), usb_dp (I/O), usb_dm (I/O)
