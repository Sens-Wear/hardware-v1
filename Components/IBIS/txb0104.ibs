| TEXAS INSTRUMENTS INCORPORATED
| 4-BIT BIDIRECTIONAL VOLTAGE-LEVEL TRANSLATOR WITH AUTO DIRECTION
| SENSING AND +/-15kV ESD PROTECTION
| This file contains package information for the following:
|  TSSOP 14-pin (PW)  package as [Component] TXB0104PW
|  SOIC  14-pin (D)   package as [Component] TXB0104D
|  QFN   14-pin (RGY) package as [Component] TXB0104RGY
|  UQFN  12-pin (RUT) package as [Component] TXB0104RUT
|  UFBGA 12-pin (GXU) package as [Component] TXB0104GXU
|  UFBGA 12-pin (ZXU) package as [Component] TXB0104ZXU
|  WCSP  12-pin (YZT) package as [Component] TXB0104YZT
| This device can be powered at the following Vccs:
|  1.2 volt Vcca
|  1.5 volt Vcca
|  1.8 volt Vcca
|  2.5 volt Vcca
|  3.3 volt Vcca
|  1.8 volt Vccb
|  2.5 volt Vccb
|  3.3 volt Vccb
|  5.0 volt Vccb
|  Vccb >= Vcca
| This file provides unique models under the [Model Selector] for each Vcc.
| For operation at a specific Vcc, select the appropriate model after each
| [Model Selector] keyword.
[IBIS Ver]   3.2
[Comment char]  |_char
[File Name]   txb0104.ibs
[File Rev]   1.3 | x_die
[Date]   November 15, 2013
[Source]   Data created from TI-SPICE simulations at TI-SLL.
[Notes]   Revision History:
| The following is an IBIS list for the TXB0104.
| Please contact sllibis@ti.com with questions and
| comments concerning SLL IBIS models.
| - FILE REV HISTORY
| - 1.3 Release IBIS file on 11/15/2013
| - RLC package section Updated on 1.3 Rev.
| - 1.2 Release IBIS file on 03/09/2009
| - As there is no power clamp diode we removed the Power Clamp
|   table data from the IN and I/O Models.
| - IBIS 3.2 SYNTAX CANNOT DESCRIBE THE CHARACTERISTICS OF
|   ANY OUTPUT STRUCTURES THAT DYNAMICALLY CHANGES THE
|   IMPEDANCES DURING THE TRANSITION. THIS DEVICE USE SIMILAR
|   OUTPUT STRUCTURE AND THEREFORE THE SIMULATION RESULTS
|   MAY NOT BE ACCURATE. TI RECOMMENDS THE USE OF SPICE
|   SIMULATION WHEN SIMULATION ACCURACY IS IMPORTANT.
| - 1.2 Release IBIS file on 03/09/09, contains addition of
|   one-shot turned on I/O circuitry in in the *_OS Models.
| - NOTE: The one-shot addition in IBIS does not contain the
|   feedback circuitry needed to turn the one-shot on (what is
|   seen in the I/O *_OS Models), or turn the one-shot off (what
|   is seen in the other I/O Models).  The Model Selector can
|   be used to select the model type.
[Disclaimer]
| Property of Texas Instruments Incorporated.  Unauthorized
| reproduction and/or distribution is strictly prohibited.
| This product is protected under copyright law.
| Created  2007, (C) Copyright  2007, Texas Instruments
| Incorporated, All Rights Reserved
| UNLESS THERE IS A SIGNED, WRITTEN AGREEMENT TO THE
| CONTRARY, TEXAS INSTRUMENTS (TI) IS PROVIDING THE IBIS
| MODELS  AND WITHOUT ANY WARRANTY, EXPRESSED OR
| IMPLIED.  TI assumes no liability for:
|  1) the accuracy of the IBIS models provided to your
|   company;
|  2) the proper functioning of these IBIS Models in your
|   design or for any resulting applications; or
|  3) infringement of patents, copyrights or intellectual
|   property rights resulting from your use of these IBIS
|   models.
| TI provides IBIS Models as a service to our customers.
| You and your company shall not distribute, sell or give
| these models to anyone else without prior written
| permission from TI.
| TI reserves the right to make changes to our products or
| to discontinue any semiconductor product or service
| without notice, and advises our customers to obtain the
| latest version of relevant information to verify, before
| placing orders, that the information being relied on is
| current.
| Please be aware that your receipt and use of the IBIS
| information provided shall serve as acceptance of these
| terms and conditions.  If you do not accept these terms,
| you should return or destroy the IBIS models and any
| other accompanying information immediately.
[Copyright]
(C) Copyright 2013 Texas Instruments Incorporated.All rights reserved.
|   TXB0104PW
[Component]   TXB0104PW
[Manufacturer]   Texas Instruments, Inc.
[Package]   |14 TSSOP - PW Package
|   typ   min   max
R_pkg   0.206987   0.18233   0.2356
L_pkg   3.11412nH   2.84422nH   3.81166nH
C_pkg   0.46668pF   0.44937pF   0.52697pF
[Pin]  signal_name   model_name   R_pin   L_pin   C_pin
1   VCCA   POWER   0.24056   3.8931nH   0.53202pF
2   A1   TXB0104_IO_A   0.2356   3.29993nH  0.47019pF
3   A2   TXB0104_IO_A   0.204   3.02853nH  0.45871pF
4   A3   TXB0104_IO_A   0.18233   2.84422nH  0.44937pF
5   A4   TXB0104_IO_A   0.18498   2.86652nH  0.45443pF
6   NC   NC   0.0047   1.56817nH  0.38338pF
7   GND   GND   0.22948   3.79178nH  0.5262pF
8   OE   TXB0104_IN   0.23165   3.81166nH  0.52697pF
9   NC   NC   0.00464   1.56313nH  0.38406pF
10   B4   TXB0104_IO_B   0.19398   2.93875nH  0.45774pF
11   B3   TXB0104_IO_B   0.19077   2.9135nH   0.45248pF
12   B2   TXB0104_IO_B   0.20545   3.03924nH  0.45951pF
13   B1   TXB0104_IO_B   0.23413   3.28471nH  0.47071pF
14   VCCB   POWER   0.24268   3.90943nH  0.53446pF
|   TXB0104D
[Component]   TXB0104D
[Manufacturer]   Texas Instruments, Inc.
[Package]   |14 SOIC - D Package
|   typ   min   max
R_pkg   0.1076267   0.08975   0.1178
L_pkg   3.2864756nH  2.87032nH   4.19006nH
C_pkg   0.570814pF   0.48576pF   0.80754pF
[Pin]  signal_name   model_name   R_pin   L_pin   C_pin
1   VCCA   POWER   0.09411   4.24601nH  0.80075pF
2   A1   TXB0104_IO_A   0.1178   3.87886nH  0.67674pF
3   A2   TXB0104_IO_A   0.11389   3.02724nH  0.49558pF
4   A3   TXB0104_IO_A   0.102   2.87032nH  0.50566pF
5   A4   TXB0104_IO_A   0.10277   2.87133nH  0.48576pF
6   NC   NC   0.0043   2.50004nH  0.59672pF
7   GND   GND   0.08886   4.18181nH  0.80593pF
8   OE   TXB0104_IN   0.08975   4.19006nH  0.80754pF
9   NC   NC   0.00428   2.49584nH  0.59772pF
10   B4   TXB0104_IO_B   0.10756   2.93944nH  0.48862pF
11   B3   TXB0104_IO_B   0.10585   2.92552nH  0.50798pF
12   B2   TXB0104_IO_B   0.11424   3.03253nH  0.49581pF
13   B1   TXB0104_IO_B   0.11478   3.84298nH  0.67364pF
14   VCCB   POWER   0.09513   4.26963nH  0.80017pF
|   TXB0104RGY
[Component]   TXB0104RGY
[Manufacturer]   Texas Instruments, Inc.
[Package]   |14 QFN - RGY Package
|   typ   min   max
R_pkg   0.03255556   0.03   0.035
L_pkg   0.733nH   0.685nH   0.783nH
C_pkg   0.317pF   0.312pF   0.323pF
[Pin]  signal_name   model_name   R_pin   L_pin   C_pin
1   VCCA   POWER   0.035   0.784nH   0.304pF
2   A1   TXB0104_IO_A   0.034   0.769nH   0.316pF
3   A2   TXB0104_IO_A   0.033   0.736nH   0.321pF
4   A3   TXB0104_IO_A   0.033   0.739nH   0.317pF
5   A4   TXB0104_IO_A   0.031   0.691nH   0.317pF
6   NC   NC   0.031   0.697nH   0.318pF
7   GND   GND   0.032   0.713nH   0.316pF
8   OE   TXB0104_IN   0.035   0.783nH   0.312pF
9   NC   NC   0.034   0.768nH   0.315pF
10   B4   TXB0104_IO_B   0.034   0.772nH   0.323pF
11   B3   TXB0104_IO_B   0.033   0.734nH   0.317pF
12   B2   TXB0104_IO_B   0.03   0.688nH   0.315pF
13   B1   TXB0104_IO_B   0.03   0.685nH   0.315pF
14   VCCB   POWER   0.034   0.773nH   0.313pF
|   TXB0104RUT
[Component]   TXB0104RUT
[Manufacturer]   Texas Instruments, Inc.
[Package]   |12 UQFN - RUT Package
|   typ   min   max
R_pkg   0.04644222   0.03845   0.05352
L_pkg   0.554676nH   0.43174nH   0.76014nH
C_pkg   0.2138067pF  0.1643pF   0.26688pF
[Pin]  signal_name   model_name   R_pin   L_pin   C_pin
1   VCCA   POWER   0.05226   0.74238nH  0.26851pF
2   A1   TXB0104_IO_A   0.04311   0.47637nH  0.18061pF
3   A2   TXB0104_IO_A   0.043   0.4761nH   0.24313pF
4   A3   TXB0104_IO_A   0.04414   0.48847nH  0.18229pF
5   A4   TXB0104_IO_A   0.04922   0.70717nH  0.26688pF
6   GND   GND   0.04552   0.51511nH  0.17056pF
7   B4   TXB0104_IO_B   0.05352   0.76014nH  0.26584pF
8   B3   TXB0104_IO_B   0.05142   0.58063nH  0.18838pF
9   B2   TXB0104_IO_B   0.0478   0.53908nH  0.24778pF
10   B1   TXB0104_IO_B   0.04732   0.53238nH  0.18505pF
11   VCCB   POWER   0.05065   0.72992nH  0.26752pF
12   OE   TXB0104_IN   0.03845   0.43174nH  0.1643pF
|   TXB0104GXU
[Component]   TXB0104GXU
[Manufacturer]   Texas Instruments, Inc.
[Package]   |12 UFBGA - GXU Package
|   typ   min   max
R_pkg   0.037889   0.024   0.078
L_pkg   1.02nH   0.739nH   1.86nH
C_pkg   0.134778pF   0.107pF   0.177pF
[Pin]  signal_name   model_name   R_pin   L_pin   C_pin
A1   A1   TXB0104_IO_A   0.048   1.15nH   0.172pF
A2   A2   TXB0104_IO_A   0.024   0.739nH   0.122pF
A3   A3   TXB0104_IO_A   0.025   0.773nH   0.108pF
A4   A4   TXB0104_IO_A   0.028   0.847nH   0.107pF
B1   VCCB   POWER   0.078   1.86nH   0.177pF
B2   VCCA   POWER   0.028   0.828nH   0.122pF
B3   OE   TXB0104_IN   0.027   0.815nH   0.112pF
B4   GND   GND   0.031   0.909nH   0.114pF
C1   B1   TXB0104_IO_B   0.03   0.871nH   0.126pF
C2   B2   TXB0104_IO_B   0.078   1.86nH   0.177pF
C3   B3   TXB0104_IO_B   0.03   0.871nH   0.126pF
C4   B4   TXB0104_IO_B   0.051   1.22nH   0.163pF
|   TXB0104ZXU
[Component]   TXB0104ZXU
[Manufacturer]   Texas Instruments, Inc.
[Package]   |12 UFBGA - ZXU Package
|   typ   min   max
R_pkg   0.0413178   0.03861   0.04602
L_pkg   1.0162578nH  0.84264nH   1.29635nH
C_pkg   0.1517533pF  0.1141pF   0.19505pF
[Pin]  signal_name   model_name   R_pin   L_pin   C_pin
A1   A1   TXB0104_IO_A   0.04344   0.89466nH  0.1141pF
A2   A2   TXB0104_IO_A   0.03999   1.10315nH  0.19505pF
A3   A3   TXB0104_IO_A   0.03874   0.91318nH  0.13873pF
A4   A4   TXB0104_IO_A   0.04237   1.2167nH   0.15831pF
B1   VCCB   POWER   0.0374   0.79572nH  0.15048pF
B2   VCCA   POWER   0.06385   3.05851nH  0.2432pF
B3   OE   TXB0104_IN   0.03861   0.84264nH  0.14573pF
B4   GND   GND   0.04341   1.28241nH  0.15168pF
C1   B1   TXB0104_IO_B   0.03872   0.87194nH  0.1332pF
C2   B2   TXB0104_IO_B   0.04076   1.12088nH  0.19143pF
C3   B3   TXB0104_IO_B   0.04321   0.88682nH  0.13587pF
C4   B4   TXB0104_IO_B   0.04602   1.29635nH  0.15336pF
|   TXB0104YZT
[Component]   TXB0104YZT
[Manufacturer]   Texas Instruments, Inc.
[Package]   |12 WCSP - ZXU Package
|   typ   min   max
R_pkg   0.00500   0.00500   0.00500
L_pkg   0.20000nH   0.20000nH   0.20000nH
C_pkg   0.60000pF   0.60000pF   0.60000pF
[Pin]  signal_name   model_name   R_pin   L_pin   C_pin
A1   B1   TXB0104_IO_B   0.005   0.2nH   0.6pF
A2   VCCB   POWER   0.005   0.2nH   0.6pF
A3   A1   TXB0104_IO_A   0.005   0.2nH   0.6pF
B1   B2   TXB0104_IO_B   0.005   0.2nH   0.6pF
B2   VCCA   POWER   0.005   0.2nH   0.6pF
B3   A2   TXB0104_IO_A   0.005   0.2nH   0.6pF
C1   B3   TXB0104_IO_B   0.005   0.2nH   0.6pF
C2   OE   TXB0104_IN   0.005   0.2nH   0.6pF
C3   A3   TXB0104_IO_A   0.005   0.2nH   0.6pF
D1   B4   TXB0104_IO_B   0.005   0.2nH   0.6pF
D2   GND   GND   0.005   0.2nH   0.6pF
D3   A4   TXB0104_IO_A   0.005   0.2nH   0.6pF
| Model TXB0104_IN
[Model Selector]   TXB0104_IN
TXB0104_IN_12A   1.2 volt Vcc
TXB0104_IN_15A   1.5 volt Vcc
TXB0104_IN_18   1.8 volt Vcc
TXB0104_IN_25   2.5 volt Vcc
TXB0104_IN_33   3.3 volt Vcc
| Model TXB0104_IO_B
[Model Selector]   TXB0104_IO_B
TXB0104_IO_B_18   1.8 volt Vcc
TXB0104_IO_B_25   2.5 volt Vcc
TXB0104_IO_B_33   3.3 volt Vcc
TXB0104_IO_B_50   5 volt Vcc
TXB0104_IO_B_OS_18   1.8 volt Vcc
TXB0104_IO_B_OS_25   2.5 volt Vcc
TXB0104_IO_B_OS_33   3.3 volt Vcc
TXB0104_IO_B_OS_50   5 volt Vcc
| Model TXB0104_IO_A
[Model Selector]   TXB0104_IO_A
TXB0104_IO_A_12A   1.2 volt Vcc
TXB0104_IO_A_15A   1.5 volt Vcc
TXB0104_IO_A_18   1.8 volt Vcc
TXB0104_IO_A_25   2.5 volt Vcc
TXB0104_IO_A_33   3.3 volt Vcc
TXB0104_IO_A_OS_12A   1.2 volt Vcc
TXB0104_IO_A_OS_15A   1.5 volt Vcc
TXB0104_IO_A_OS_18   1.8 volt Vcc
TXB0104_IO_A_OS_25   2.5 volt Vcc
TXB0104_IO_A_OS_33   3.3 volt Vcc
| Models and submodels in the file (23): TXB0104_IN_12A (Input), TXB0104_IN_15A (Input), TXB0104_IN_18 (Input), TXB0104_IN_25 (Input), TXB0104_IN_33 (Input), TXB0104_IO_B_18 (I/O), TXB0104_IO_B_25 (I/O), TXB0104_IO_B_33 (I/O), TXB0104_IO_B_50 (I/O), TXB0104_IO_B_OS_18 (I/O), TXB0104_IO_B_OS_25 (I/O), TXB0104_IO_B_OS_33 (I/O), TXB0104_IO_B_OS_50 (I/O), TXB0104_IO_A_12A (I/O), TXB0104_IO_A_15A (I/O), TXB0104_IO_A_18 (I/O), TXB0104_IO_A_25 (I/O), TXB0104_IO_A_33 (I/O), TXB0104_IO_A_OS_12A (I/O), TXB0104_IO_A_OS_15A (I/O), TXB0104_IO_A_OS_18 (I/O), TXB0104_IO_A_OS_25 (I/O), TXB0104_IO_A_OS_33 (I/O)
